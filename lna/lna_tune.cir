* LNA Matching Tune
.lib "../../../../junk/vco/IHP-Open-PDK-0.3.0/ihp-sg13g2/libs.tech/ngspice/models/cornerHBT.lib" hbt_typ

.subckt lna_core in out vdd vss
    X1 c b e vss npn13G2l m=1
    R_bias vdd b 20k

    * Input Matching
    C_in in node_x 280f
    L_in node_x b 390p

    L_e e vss 50pH
    L_load vdd c 150pH
    C_out c out 150f
.ends

V_vdd vdd 0 1.2
V_vss vss 0 0

V1 in 0 dc 0 ac 1 portnum=1 z0=50
V2 out 0 dc 0 ac 0 portnum=2 z0=50

X_lna in out vdd vss lna_core

.control
    sp dec 50 20G 40G 0
    let f30 = 30G
    let freq_diff = abs(frequency - f30)
    let min_diff = vecmin(freq_diff)

    * Write out S11 magnitude at 30GHz
    wrdata s11_out.txt S_1_1 S_2_1
    quit
.endc
.end
