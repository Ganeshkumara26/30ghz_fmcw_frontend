* 30 GHz Mixer Standalone — Xyce (from v65 real-PDK, FIXED)
* ==============================================================================
* Double-balanced Gilbert cell, exactly matching v65 topology
* RF input through attenuator pad (500+200 Ohm, per v65 line 301-302)
* LO at 30.001 GHz (1 MHz IF offset for conversion gain extraction)
* FIX: Cleaned up RF input biasing to match v65 exactly
* ==============================================================================
.lib /tmp/ihp_sg13g2/libs.tech/xyce/models/cornerHBT.lib hbt_typ
.lib /tmp/ihp_sg13g2/libs.tech/xyce/models/cornerRES.lib res_typ
.lib /tmp/ihp_sg13g2/libs.tech/xyce/models/cornerCAP.lib cap_typ

.options NONLIN MAXSTEP=200
.options DEVICE temp=27

Vdd vdd 0 1.2

* RF Input: 30 GHz, 10mV (moderate drive for conversion gain test)
V_rf rf_in 0 SIN(0 0.01 30G)

* AC coupling from RF source
C_ac_rf rf_in mx_rf_p 1p

* RF transconductor bias (0.85V for npn13G2)
R_bmix_p1 vdd mx_rf_p 1k
R_bmix_p2 mx_rf_p 0 2.4k
R_bmix_n1 vdd mixer_rf_n 1k
R_bmix_n2 mixer_rf_n 0 2.4k

* RF transconductor pair (per v65 lines 309-311)
X_mix_1 c1 mx_rf_p rf_tail 0 npn13G2 PARAMS: Nx=4
X_mix_2 c2 mixer_rf_n rf_tail 0 npn13G2 PARAMS: Nx=4
I_rftail rf_tail 0 4m

* LO buffer pair (per v65 lines 313-317)
X_lobuf_1 lo_buf_p lo_p lo_tail 0 npn13G2 PARAMS: Nx=2
X_lobuf_2 lo_buf_n lo_n lo_tail 0 npn13G2 PARAMS: Nx=2
R_lobuf_p vdd lo_buf_p 200
R_lobuf_n vdd lo_buf_n 200
I_lobuf_tail lo_tail 0 2m

* LO source (1 MHz offset for IF extraction, per v65 lines 319-320)
V_lo_p lo_p 0 SIN(0 0.5 30.001G)
V_lo_n lo_n 0 SIN(0 0.5 30.001G 0 0 180)

* Switching quad (per v65 lines 322-327)
X_mix_3 if_p lo_buf_p c1 0 npn13G2 PARAMS: Nx=4
X_mix_4 if_p lo_buf_n c2 0 npn13G2 PARAMS: Nx=4
X_mix_5 if_n lo_buf_n c1 0 npn13G2 PARAMS: Nx=4
X_mix_6 if_n lo_buf_p c2 0 npn13G2 PARAMS: Nx=4

* IF load resistors
R_ld_p vdd if_p 200
R_ld_n vdd if_n 200

* Analysis
.tran 0.5p 20n 0 0.5p

.measure tran mix_if_vpp_p PP v(if_p) FROM=15n TO=20n
.measure tran mix_if_vpp_n PP v(if_n) FROM=15n TO=20n
.measure tran mix_lo_vpp PP v(lo_buf_p) FROM=15n TO=20n
.measure tran mix_lo_leak PP v(c1) FROM=15n TO=20n
.measure tran mix_if_dc_p AVG v(if_p) FROM=15n TO=20n
.measure tran mix_rf_in PP v(rf_in) FROM=15n TO=20n

.print tran v(if_p) v(if_n) v(c1) v(c2) v(lo_buf_p) v(lo_buf_n) v(rf_in)

.end
