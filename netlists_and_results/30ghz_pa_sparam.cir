* 30 GHz PA S-Parameter Extraction — Xyce
* ==============================================================================
.lib /tmp/ihp_sg13g2/libs.tech/xyce/models/cornerHBT.lib hbt_typ
.lib /tmp/ihp_sg13g2/libs.tech/xyce/models/cornerRES.lib res_typ
.lib /tmp/ihp_sg13g2/libs.tech/xyce/models/cornerCAP.lib cap_typ

.options NONLIN MAXSTEP=200
.options DEVICE temp=27

Vdd_pa vdd_pa 0 3.0

* Single-Ended Port Drive for S-Parameters
P1 in_ac_p 0 port=1 z0=50
C_ac_gnd_in in_ac_n 0 100u

* === AC-coupled input + base bias ===
C_ac_in_n in_ac_n pa_in_n 1p
C_ac_in_p in_ac_p pa_in_p 1p

* Base bias for CE stage
R_b1_n vdd_pa pa_in_n 1k
R_b2_n pa_in_n 0 400
R_b1_p vdd_pa pa_in_p 1k
R_b2_p pa_in_p 0 400

* === CASCODE CE STAGE (Nx=32) ===
X_pa_ce_n pa_mid_n pa_in_n pa_emit 0 npn13G2 PARAMS: Nx=32
X_pa_ce_p pa_mid_p pa_in_p pa_emit 0 npn13G2 PARAMS: Nx=32

* Degeneration / Tail
R_tail pa_emit 0 2.5

* === CASCODE CB STAGE (Nx=32) ===
R_cb1 vdd_pa cbias 300
R_cb2 cbias 0 450
C_cb cbias 0 10p

* Cascode R-C Snubber (In-Band Stabilization)
.param r_snub = 10
.param c_snub = 30f
R_snub_n pa_mid_n pa_snub_n {r_snub}
C_snub_n pa_snub_n 0 {c_snub}
R_snub_p pa_mid_p pa_snub_p {r_snub}
C_snub_p pa_snub_p 0 {c_snub}

X_pa_cb_n out_n cbias pa_mid_n 0 npn13G2 PARAMS: Nx=32
X_pa_cb_p out_p cbias pa_mid_p 0 npn13G2 PARAMS: Nx=32

* === OUTPUT NETWORK ===
.include ind_125pH_model.cir
X_load_n vdd_pa out_n 0 ind_125pH_model
X_load_p vdd_pa out_p 0 ind_125pH_model
C_res_n out_n 0 22f
C_res_p out_p 0 22f

* Near-DC Stabilization (Out-of-band loading)
R_out_stab_n out_n out_stab_n 20
C_out_stab_n out_stab_n 0 50p
R_out_stab_p out_p out_stab_p 20
C_out_stab_p out_stab_p 0 50p

* Output Port
P2 out_p 0 port=2 z0=50
C_ac_gnd_out out_n 0 100u

* Analysis
.LIN SPARCALC=1 FORMAT=TOUCHSTONE FILE=pa_350GHz.s2p
.AC DEC 50 10MEG 350G

.end
