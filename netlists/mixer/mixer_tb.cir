* 30 GHz Gilbert Cell Mixer Testbench — IHP SG13G2
* Validates conversion gain, isolation, and linearity

.lib "../vco/netlist/parameters.inc"

* PDK models — adjust path as needed
* .lib "../../../../pdk/IHP-Open-PDK/ihp-sg13g2/libs.tech/ngspice/models/cornerHBT.lib" hbt_typ

* Supplies
V_vdd vdd 0 1.2
V_vss vss 0 0

* LO Input (30 GHz, 0 dBm differential)
V_lo_p lo_p 0 dc 0 sin(0 0.1 30G)
V_lo_n lo_n 0 dc 0 sin(0 -0.1 30G)

* RF Input (30.001 GHz, -30 dBm — 1 MHz offset for IF)
V_rf_p rf_p 0 dc 0 sin(0 0.01 30.001G)
V_rf_n rf_n 0 dc 0 sin(0 -0.01 30.001G)

* IF Load
R_if_p if_p vss 200
R_if_n if_n vss 200

* Instantiate Mixer
X_mix rf_p rf_n lo_p lo_n if_p if_n vdd vss mixer_gilbert

* Mixer subcircuit (inline for test)
.subckt mixer_gilbert RF_p RF_n LO_p LO_n IF_p IF_n VDD VSS
    Q1 c1 RF_p e_tail VSS npn13G2l m=1
    Q2 c2 RF_n e_tail VSS npn13G2l m=1
    Q3 c3 LO_p c1 VSS npn13G2l m=1
    Q4 c4 LO_p c2 VSS npn13G2l m=1
    Q5 c3 LO_n c2 VSS npn13G2l m=1
    Q6 c4 LO_n c1 VSS npn13G2l m=1
    R_load_p VDD IF_p 200
    R_load_n VDD IF_n 200
    V_if_p IF_p c3 0
    V_if_n IF_n c4 0
    I_tail e_tail VSS 2m
.ends

.control
    * Transient simulation to observe mixing product
    tran 0.1n 50n

    * Measure IF frequency (should be 1 MHz = 30 GHz - 30.001 GHz)
    meas tran IF_freq WHEN V(if_p)=0 RISE=10

    * Print results
    print v(if_p) v(if_n)

    quit
.endc
.end
