* Complete 30 GHz Radar Frontend Verification - Tapeout Ready
* PDK models: IHP SG13G2 (absolute paths, same root as the validated block netlists)
.lib "/tmp/ihp_sg13g2/libs.tech/ngspice/models/cornerHBT.lib" hbt_bcs
.lib "/tmp/ihp_sg13g2/libs.tech/ngspice/models/cornerCAP.lib" cap_wcs
.lib "/tmp/ihp_sg13g2/libs.tech/ngspice/models/cornerRES.lib" res_typ

.options method=gear reltol=1e-3 temp=27

* Supplies
Vdd_1p2 vdd_1p2 0 1.32
Vdd_2p5 vdd_2p5 0 2.75
Vss vss 0 0
V_clk clk 0 dc 0 pulse(0 1.2 0 0.1n 0.1n 4.9n 10n)
V_ref_p vref_p 0 1.0
V_ref_n vref_n 0 0

* =============================================================================
* IMPORTED FINALIZED SUBCIRCUITS
* =============================================================================

* 1. LNA (from lna_matched_tb.cir)
.subckt lna_30ghz_matched IN OUT VDD VSS
    L_series IN match_node 180p
    C_shunt match_node VSS 40f
    C_block match_node base_in 200f
    R_bias VDD base_in 15k
    X1 coll base_in emit VSS npn13G2l m=1
    L_deg emit VSS 60p
    X2 out_int cb_bias coll VSS npn13G2l m=1
    C_bypass cb_bias VSS 2p
    R_cb VDD cb_bias 10k
    * BUG FIX: L_bond previously shorted cb_bias to coll (Base-Emitter short), turning off X2!
    * L_bond cb_bias coll 100p
    L_load VDD out_int 120p
    C_res out_int VSS 35f
    C_out out_int OUT 120f
.ends lna_30ghz_matched

* 2. VCO (from vco_30ghz.cir topology)
.subckt vco_30ghz OUT_P OUT_N VDD VSS
    L1 VDD c1 150p
    L2 VDD c2 150p
    X1 c1 c2 emit VSS npn13G2l m=2
    X2 c2 c1 emit VSS npn13G2l m=2
    C1 c1 VSS 100f
    C2 c2 VSS 100f
    I_tail emit VSS 4m
    C_out1 c1 OUT_P 100f
    C_out2 c2 OUT_N 100f
    R1 OUT_P VSS 1Meg
    R2 OUT_N VSS 1Meg
.ends vco_30ghz

* 3. PA (from pa_classE.cir)
.subckt pa_classE IN OUT VDD VSS
    L_match in_int IN 200p
    C_match in_int VSS 100f
    X1 coll in_int emit_pa VSS npn13G2l m=8
    R_bias VDD in_int 5k
    L_load VDD coll 120p
    C_res coll VSS 40f
    C_out coll OUT 200f
    C_shunt OUT VSS 30f
    R_emit emit_pa VSS 0.5
.ends pa_classE

* 4. Mixer (from mixer_gilbert.cir)
.subckt mixer_gilbert RF_p RF_n LO_p LO_n IF_p IF_n VDD VSS
    X1 c1 b_e1 e_tail VSS npn13G2l m=1
    X2 c2 b_e2 e_tail VSS npn13G2l m=1
    C_be1 RF_p b_e1 50f
    C_be2 RF_n b_e2 50f
    * RF Base biasing (VDD=2.5V, base=~0.9V)
    R_bias_rf1 VDD b_e1 18k
    R_bias_rf2 b_e1 VSS 10k
    R_bias_rf3 VDD b_e2 18k
    R_bias_rf4 b_e2 VSS 10k
    X3 c3 b_lo_p c1 VSS npn13G2l m=1
    X4 c4 b_lo_p c2 VSS npn13G2l m=1
    X5 c3 b_lo_n c2 VSS npn13G2l m=1
    X6 c4 b_lo_n c1 VSS npn13G2l m=1
    C_lo1 LO_p b_lo_p 100f
    C_lo2 LO_n b_lo_n 100f
    * LO Base biasing (VDD=2.5V, base=~1.7V)
    R_bias_lo1 VDD b_lo_p 10k
    R_bias_lo2 b_lo_p VSS 20k
    R_bias_lo3 VDD b_lo_n 10k
    R_bias_lo4 b_lo_n VSS 20k
    R_load_p VDD IF_p 600
    R_load_n VDD IF_n 600
    V_if_p IF_p c3 0
    V_if_n IF_n c4 0
    I_tail e_tail VSS 2m
    C_bypass e_tail VSS 5p
.ends mixer_gilbert

* 5. ADC (from adc_sar_behavioral.cir)
.subckt adc_sar_behavioral in clk out_0 out_1 out_2 out_3 out_4 out_5 out_6 out_7 vref_p vref_n vdd vss
    E_quantize out_analog vss vol='floor((v(in))/(v(vref_p)) * 255) / 255 * (v(vref_p))'
.ends adc_sar_behavioral

* 6. Buffer (Emitter Follower)
.subckt buffer_ef IN OUT VDD VSS
    R_b1 VDD IN 10k
    R_b2 IN VSS 20k
    X1 VDD IN emit VSS npn13G2l m=2
    R_emit emit VSS 500
    R_damp emit OUT 20
.ends buffer_ef

.subckt pa_predriver IN OUT VDD VSS
    C_in IN base_in 1p
    R_bias1 VDD base_in 10k
    R_bias2 base_in VSS 5k
    X1 coll base_in emit VSS npn13G2l m=4
    R_emit emit VSS 0.5
    L_load VDD coll 150p
    C_res coll VSS 50f
    C_out coll OUT 300f
.ends pa_predriver

* 7. Balun (Transformer-based, tapeout ready)
.subckt balun_transformer in p n bias vdd vss
    L_pri in pri_int 80p
    R_pri_loss pri_int vss 0.1
    L_sec1 p bias 80p
    L_sec2 bias n 80p
    K1 L_pri L_sec1 0.7
    K2 L_pri L_sec2 0.7
    K3 L_sec1 L_sec2 0.95
.ends balun_transformer

* 8. IF Amplifier (2-Stage)
.subckt if_2stage IN OUT VDD VSS
    C_couple1 IN b1 10n
    R_b1_1 VDD b1 15k
    R_b1_2 b1 VSS 10k
    X1 c1 b1 e1 VSS npn13G2l m=2
    R_load1 VDD c1 390
    R_e1 e1 VSS 75

    C_couple2 c1 b2 10n
    R_b2_1 VDD b2 15k
    R_b2_2 b2 VSS 10k
    X2 c2 b2 e2 VSS npn13G2l m=2
    R_load2 VDD c2 390
    R_e2 e2 VSS 75

    C_out c2 OUT 10n
.ends if_2stage

* =============================================================================
* SYSTEM INTEGRATION
* =============================================================================

* 1. VCO
X_vco vco_out_p vco_out_n vdd_1p2 vss vco_30ghz

* 2. Buffer (new)
X_buf vco_out_p buf_out vdd_2p5 vss buffer_ef
X_buf_dummy vco_out_n buf_out_dummy vdd_2p5 vss buffer_ef

* 3. PA
X_predrv buf_out predrv_out vdd_2p5 vss pa_predriver
    X_pa predrv_out pa_out vdd_2p5 vss pa_classE

* 4. Radar Channel (Physical Path Loss ~ 100dB Attenuation + Target Summing)
* The PA must be physically terminated into a 50 ohm antenna
R_pa_load pa_out vss 50
E_channel pa_leakage vss pa_out vss 0.00001
V_target target_node vss dc 0 sin(0 0.0001 30.1G 0 0)
E_rx_sum rx_sum_node vss vol='v(target_node) + v(pa_leakage)'
R_source rx_sum_node rx_in 50

* 5. LNA
X_lna rx_in lna_out vdd_1p2 vss lna_30ghz_matched

* 6. Balun (new)
R_balun_b1 vdd_1p2 mix_bias 10k
R_balun_b2 mix_bias vss 10k
C_balun_b mix_bias vss 1p
X_balun lna_out mix_rf_p mix_rf_n mix_bias vdd_1p2 vss balun_transformer

* 7. Mixer
X_mix mix_rf_p mix_rf_n vco_out_p vco_out_n if_p if_n vdd_2p5 vss mixer_gilbert

* IF Filter (to remove 30 GHz LO feedthrough without killing unknown physical IF frequency)
C_if_filter_p if_p vss 0.1p
C_if_filter_n if_n vss 0.1p

* 8. IF Amplifier (new)
X_if_amp if_p if_amp_out vdd_2p5 vss if_2stage
R_adc_load if_amp_out vss 1Meg

* 9. ADC (Transistor Level)
.include "adc/adc_sar_transistor.cir"
X_adc if_amp_out clk adc_0 adc_1 adc_2 adc_3 adc_4 adc_5 adc_6 adc_7 vref_p vref_n vdd_1p2 vss adc_sar_transistor

* =============================================================================
* ANALYSIS
* =============================================================================
I_startup vdd_1p2 x_vco.c1 pulse(0 2m 0 10p 10p 50p 100n)
.control
    tran 1p 25n

    * Measure VCO Amplitude
    meas tran vco_vpp PP v(vco_out_p) from=10n to=25n
    * Measure Buffer Amplitude
    meas tran buf_vpp PP v(buf_out) from=10n to=25n
    * Measure Pre-Driver Amplitude
    meas tran predrv_vpp PP v(predrv_out) from=10n to=25n
    * Measure PA Amplitude
    meas tran pa_vpp PP v(pa_out) from=10n to=25n
    * Measure LNA Amplitude
    meas tran lna_vpp PP v(lna_out) from=10n to=25n
    * Measure Mixer Output Amplitude (Now capturing 100MHz IF)
    meas tran if_mix_vpp PP v(if_p) from=10n to=25n

    * Measure true IF Amp output (Now capturing 100MHz IF)
    meas tran if_amp_ripple_vpp PP v(if_amp_out) from=10n to=25n

    * Estimate Total System Current
    let i_vdd12 = -Vdd_1p2#branch
    let i_vdd25 = -Vdd_2p5#branch
    let p_total = (i_vdd12 * 1.2) + (i_vdd25 * 2.5)
    print p_total

    quit
.endc
.end
