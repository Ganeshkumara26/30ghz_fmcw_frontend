* 30 GHz Radar — Mixed-Signal Top-Level
* =============================================================================
* Connects the Analog Front-End (AFE) to the Digital DSP pipeline
*
* Signal Flow:
*   VCO (30 GHz) → PA → (Antenna/Target) → LNA → Mixer → IF → ADC → DSP
*
* This file defines the connectivity between analog and digital domains.
* For full mixed-signal simulation, use Verilog-AMS or connect in a
* top-level testbench with A-to-D bridges.

* =============================================================================
* ANALOG FRONT-END INSTANTIATION
* =============================================================================

* VCO: 30 GHz LO generation
X_vco lo_p lo_n vdd_1p2 vss vco_30ghz_core
.subckt vco_30ghz_core out_p out_n vdd vss
    V_osc_p out_p vss dc 0 sin(0 0.5 30G 0 0)
    V_osc_n out_n vss dc 0 sin(0 -0.5 30G 0 0)
.ends

* PA: Transmit power amplifier
X_pa lo_p tx_out vdd_2p5 vss pa_classE
.subckt pa_classE IN OUT VDD VSS
    L_match in_int IN 200p
    C_match in_int VSS 100f
    Q1 coll in_int emit_pa VSS npn13G2l m=4
    R_bias VDD in_int 5k
    L_load VDD coll 150p
    C_res coll VSS 50f
    C_out coll OUT 150f
    C_shunt OUT VSS 30f
    R_emit emit_pa VSS 1
.ends

* Channel: Target reflection (50m delay + attenuation)
T_channel tx_out 0 rx_in 0 Z0=50 TD=333p
R_atten rx_in vss 50
V_rx rx_in vss dc 0 sin(0 0.001 30G 0 0)

* LNA: Low-noise amplifier with matching
X_lna rx_in lna_out vdd_1p2 vss lna_30ghz_matched
.subckt lna_30ghz_matched IN OUT VDD VSS
    L_series IN match_node 180p
    C_shunt match_node VSS 40f
    C_block match_node base_in 200f
    R_bias VDD base_in 15k
    Q1 coll base_in emit VSS npn13G2l m=1
    L_deg emit VSS 60p
    Q2 out_int coll VSS npn13G2l m=1
    C_bypass cb_bias VSS 2p
    R_cb VDD cb_bias 10k
    L_bond cb_bias coll 100p
    L_load VDD out_int 120p
    C_res out_int VSS 35f
    C_out out_int OUT 120f
    L_shunt OUT VSS 80p
.ends

* Mixer: Downconversion (RF + LO → IF)
X_mix lna_out vss lo_p lo_n if_p if_n vdd_1p2 vss mixer_gilbert
.subckt mixer_gilbert RF_p RF_n LO_p LO_n IF_p IF_n VDD VSS
    Q1 c1 RF_p e_tail VSS npn13G2l m=1
    Q2 c2 RF_n e_tail VSS npn13G2l m=1
    Q3 c3 LO_p c1 VSS npn13G2l m=1
    Q4 c4 LO_p c2 VSS npn13G2l m=1
    Q5 c3 LO_n c2 VSS npn13G2l m=1
    Q6 c4 LO_n c1 VSS npn13G2l m=1
    R_load_p VDD IF_p 200
    R_load_n VDD IF_n 200
    V_if_p IF_p c3 0
    V_if_n IF_n c4 0
    I_tail e_tail VSS 2m
.ends

* =============================================================================
* ANALOG-TO-DIGITAL INTERFACE
* =============================================================================
* IF signal → ADC → Digital bits → DSP pipeline

* ADC behavioral model (8-bit)
X_adc if_p clk adc_bit_0 adc_bit_1 adc_bit_2 adc_bit_3 adc_bit_4 adc_bit_5 adc_bit_6 adc_bit_7 vref_p vref_n vdd_1p2 vss adc_sar_behavioral
.subckt adc_sar_behavioral in clk out_0 out_1 out_2 out_3 out_4 out_5 out_6 out_7 vref_p vref_n vdd vss
    E_quantize out_analog vss vol='floor((v(in))/(v(vref_p)) * 255) / 255 * (v(vref_p))'
.ends

* ADC clock (100 MHz)
V_clk clk 0 pulse(0 1.2 0 0.1n 0.1n 4.9n 10n)

* ADC reference
V_ref_p vref_p 0 1.0
V_ref_n vref_n 0 0

* =============================================================================
* DIGITAL DSP PIPELINE (connected via Verilog in full mixed-sim)
* =============================================================================
* The ADC outputs (adc_bit_0..7) connect to the digital_top module:
*
*   digital_top u_digital (
*       .adc_data({adc_bit_7, adc_bit_6, ..., adc_bit_0}),
*       .adc_valid(adc_valid),
*       .adc_last(adc_last),
*       .clk(clk),
*       .rst_n(rst_n),
*       .ext_read_addr(edp_addr),
*       .ext_read_req(edp_req),
*       .ext_read_data(edp_data),
*       .ext_read_ack(edp_ack)
*   );
*
* For pure analog simulation, the IF output is observed directly.

* =============================================================================
* SUPPLIES
* =============================================================================
V_vdd_1p2 vdd_1p2 0 1.2
V_vdd_2p5 vdd_2p5 0 2.5
V_vss vss 0 0

* Mixed-signal simulation requires:
* 1. Verilog-A/AMS A-to-D bridge (or XSPICE adc_bridge)
* 2. Co-simulation with iverilog/vvp for digital
* 3. Or: export ADC output samples and feed to SystemVerilog testbench

.control
    * Operating point
    op
    print v(tx_out) v(lna_out) v(if_p) v(if_n)

    * Transient
    tran 0.1n 200n

    * FFT of IF to verify beat frequency
    fft v(if_p)

    quit
.endc
.end
