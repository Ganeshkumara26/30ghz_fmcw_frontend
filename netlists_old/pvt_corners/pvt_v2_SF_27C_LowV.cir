* Complete 30 GHz Radar Frontend Verification - Tapeout Ready
* PDK models: IHP SG13G2 (absolute paths, same root as the validated block netlists)
.lib "/mnt/d/Desktop/Vault/03 Projects/junk/vco/IHP-Open-PDK-0.3.0/ihp-sg13g2/libs.tech/ngspice/models/cornerHBT.lib" hbt_wcs
.lib "/mnt/d/Desktop/Vault/03 Projects/junk/vco/IHP-Open-PDK-0.3.0/ihp-sg13g2/libs.tech/ngspice/models/cornerCAP.lib" cap_bcs
.lib "/mnt/d/Desktop/Vault/03 Projects/junk/vco/IHP-Open-PDK-0.3.0/ihp-sg13g2/libs.tech/ngspice/models/cornerRES.lib" res_typ

.options method=gear reltol=1e-3 cshunt=1f temp=27

* Supplies
Vdd_1p2 vdd_1p2 0 1.08
Vdd_2p5 vdd_2p5 0 2.25
Vss vss 0 0
V_clk clk 0 dc 0 pulse(0 1.2 0 0.1n 0.1n 4.9n 10n)
V_ref_p vref_p 0 1.0
V_ref_n vref_n 0 0

* =============================================================================
* IMPORTED FINALIZED SUBCIRCUITS
* =============================================================================

* 1. LNA (from lna_matched_tb.cir)
.subckt lna_30ghz_matched IN OUT VDD VSS
    L_series IN match_node 180p
    C_shunt match_node VSS 40f
    C_block match_node base_in 200f
    R_bias VDD base_in 15k
    X1 coll base_in emit VSS npn13G2l m=1
    L_deg emit VSS 60p
    X2 out_int cb_bias coll VSS npn13G2l m=1
    C_bypass cb_bias VSS 2p
    R_cb VDD cb_bias 10k
    * BUG FIX: L_bond previously shorted cb_bias to coll (Base-Emitter short), turning off X2!
    * L_bond cb_bias coll 100p
    L_load VDD out_int 120p
    C_res out_int VSS 35f
    C_out out_int OUT 120f
.ends lna_30ghz_matched

* 2. VCO (from vco_30ghz.cir topology)
.subckt vco_30ghz OUT_P OUT_N VDD VSS
    L1 VDD c1 150p
    L2 VDD c2 150p
    X1 c1 c2 emit VSS npn13G2l m=2
    X2 c2 c1 emit VSS npn13G2l m=2
    R_tank1 c1 VDD 400
    R_tank2 c2 VDD 400
    C1 c1 VSS 100f
    C2 c2 VSS 100f
    I_tail emit VSS 4m
    C_out1 c1 OUT_P 100f
    C_out2 c2 OUT_N 100f
    R1 OUT_P VSS 1Meg
    R2 OUT_N VSS 1Meg
.ends vco_30ghz

* 4. Mixer (from mixer_gilbert.cir)
.subckt mixer_gilbert RF_p RF_n LO_p LO_n IF_p IF_n VDD VSS
    X1 c1 b_e1 e_tail VSS npn13G2l m=1
    X2 c2 b_e2 e_tail VSS npn13G2l m=1
    C_be1 RF_p b_e1 50f
    C_be2 RF_n b_e2 50f
    * RF Base biasing (VDD=2.5V, base=~0.9V)
    R_bias_rf1 VDD b_e1 18k
    R_bias_rf2 b_e1 VSS 10k
    R_bias_rf3 VDD b_e2 18k
    R_bias_rf4 b_e2 VSS 10k
    X3 c3 b_lo_p c1 VSS npn13G2l m=1
    X4 c4 b_lo_p c2 VSS npn13G2l m=1
    X5 c3 b_lo_n c2 VSS npn13G2l m=1
    X6 c4 b_lo_n c1 VSS npn13G2l m=1
    C_lo1 LO_p b_lo_p 100f
    C_lo2 LO_n b_lo_n 100f
    * LO Base biasing (VDD=2.5V, base=~1.7V)
    R_bias_lo1 VDD b_lo_p 10k
    R_bias_lo2 b_lo_p VSS 20k
    R_bias_lo3 VDD b_lo_n 10k
    R_bias_lo4 b_lo_n VSS 20k
    R_load_p VDD IF_p 600
    R_load_n VDD IF_n 600
    V_if_p IF_p c3 0
    V_if_n IF_n c4 0
    I_tail e_tail VSS 2m
    C_bypass e_tail VSS 5p
.ends mixer_gilbert

* 5. ADC (from adc_sar_behavioral.cir)
.subckt adc_sar_behavioral in clk out_0 out_1 out_2 out_3 out_4 out_5 out_6 out_7 vref_p vref_n vdd vss
    E_quantize out_analog vss vol='floor((v(in))/(v(vref_p)) * 255) / 255 * (v(vref_p))'
.ends adc_sar_behavioral

* 7. Balun (Transformer-based, tapeout ready)
.subckt balun_transformer in p n bias vdd vss
    L_pri in pri_int 80p
    R_pri_loss pri_int vss 0.1
    L_sec1 p bias 80p
    L_sec2 bias n 80p
    K1 L_pri L_sec1 0.7
    K2 L_pri L_sec2 0.7
    K3 L_sec1 L_sec2 0.95
.ends balun_transformer

* =============================================================================
* NEW PRODUCTION-GRADE SUBCIRCUITS
* =============================================================================
.include "vco/netlists/cml_lo_buffer.cir"
.include "pa/netlists/pa_classAB_differential.cir"
.include "baseband/netlists/opamp_driver.cir"
.include "frontend/netlists/tx_leakage_canceller.cir"

* =============================================================================
* SYSTEM INTEGRATION
* =============================================================================

* 1. VCO
X_vco vco_out_p vco_out_n vdd_1p2 vss vco_30ghz

* 2. LO Buffer (CML for isolation)
X_lo_buf_p vco_out_p vco_out_n lo_buf_p lo_buf_n vdd_1p2 vss cml_buffer

* 3. Differential Cascode Class-AB PA
X_pa vco_out_p vco_out_n pa_out_p pa_out_n vdd_2p5 vss pa_classAB_differential

* 4. TX Balun
* Output connects to balun secondary (p, n). Primary connects to antenna.
X_tx_balun tx_ant pa_out_p pa_out_n vdd_2p5 vdd_2p5 vss balun_transformer

* 5. Radar Channel (Physical Path Loss ~ 40dB Realistic Attenuation)
* Physical 50 ohm antenna matching
R_pa_load tx_ant vss 50

* Leakage is 40dB (-100x power, so 0.01x voltage)
E_channel pa_leakage vss tx_ant vss 0.01

* Target reflection (100dB path loss, frequency shifted by 100MHz)
V_target target_node vss dc 0 sin(0 0.0001 30.1G 0 0)
E_rx_sum rx_sum_node vss vol='v(target_node) + v(pa_leakage)'
R_source rx_sum_node rx_in 50

* 6. TX Leakage Canceller
* Active feedforward path: taps tx_ant, phase-shifts 180 deg, and scales to exactly cancel leakage.
* V_ctrl set to 1.5V for ~40dB attenuation range.
V_ctrl v_ctrl_cancel 0 1.5
X_canceller tx_ant cancel_inject v_ctrl_cancel vdd_2p5 vss tx_leakage_canceller

* 7. LNA
* The input to the LNA is the sum of the RX antenna signal and the active cancellation injection.
C_cancel_couple cancel_inject rx_in 1p
X_lna rx_in lna_out vdd_1p2 vss lna_30ghz_matched

* 8. RX Balun
R_balun_b1 vdd_1p2 mix_bias 10k
R_balun_b2 mix_bias vss 10k
C_balun_b mix_bias vss 1p
X_rx_balun lna_out mix_rf_p mix_rf_n mix_bias vdd_1p2 vss balun_transformer

* 9. Mixer (Gilbert Cell)
* Driven by the isolated CML buffer!
X_mix mix_rf_p mix_rf_n lo_buf_p lo_buf_n if_p if_n vdd_2p5 vss mixer_gilbert

* IF Filter (to remove 30 GHz LO feedthrough without killing 100MHz IF)
C_if_filter_p if_p vss 0.1p
C_if_filter_n if_n vss 0.1p

* 10. Baseband OpAmp (Active Anti-Aliasing Filter & ADC Driver)
* Drives the SAR ADC, acts as low-pass filter (fc = 176MHz)
X_opamp if_p if_n opamp_out vdd_2p5 vss opamp_driver

* 11. ADC (Transistor Level)
.include "adc/netlists/adc_sar_transistor.cir"
X_adc dummy_adc_in clk adc_0 adc_1 adc_2 adc_3 adc_4 adc_5 adc_6 adc_7 vref_p vref_n vdd_1p2 vss adc_sar_transistor

I_startup vdd_1p2 x_vco.c1 pulse(0 2m 0 1n 1n 2n 100n)
.control
    tran 1p 30n

    * Measure VCO Amplitude
    meas tran vco_vpp PP v(vco_out_p) from=15n to=30n
    * Measure Buffer Amplitude
    * meas tran buf_vpp PP v(buf_out) from=15n to=30n
    * Measure Pre-Driver Amplitude
    * meas tran predrv_vpp PP v(predrv_out) from=15n to=30n
    * Measure PA Amplitude
    meas tran pa_vpp PP v(tx_ant) from=15n to=30n
    * Measure LNA Amplitude
    meas tran lna_vpp PP v(lna_out) from=15n to=30n
    * Measure Mixer Output Amplitude (Now capturing 100MHz IF)
    meas tran if_mix_vpp PP v(if_p) from=15n to=30n

    * Measure true IF Amp output (Now capturing 100MHz IF)
    meas tran if_amp_ripple_vpp PP v(opamp_out) from=15n to=30n

    * Estimate Total System Current
    let i_vdd12 = -Vdd_1p2#branch
    let i_vdd25 = -Vdd_2p5#branch
    let p_total = (i_vdd12 * 1.2) + (i_vdd25 * 2.5)
    print p_total

    set filetype=ascii
    write pvt_v2_SF_27C_LowV.raw v(opamp_out) v(tx_ant)

    quit
.endc
.end
