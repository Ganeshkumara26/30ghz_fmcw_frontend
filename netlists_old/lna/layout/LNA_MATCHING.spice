* SPICE3 file created from LNA_MATCHING.ext - technology: minimum

.option scale=1u
