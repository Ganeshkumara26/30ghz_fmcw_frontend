* 30 GHz LNA S-Parameter Verification (IHP SG13G2)
.lib "../../../../junk/vco/IHP-Open-PDK-0.3.0/ihp-sg13g2/libs.tech/ngspice/models/cornerHBT.lib" hbt_typ

* Basic Common Emitter LNA Core
.subckt lna_core in out vdd vss
    * Simple Biasing (ideal components for isolation)
    R_bias vdd b 10k
    C_in in b 1pF

    * IHP SG13G2 NPN HBT
    X1 c b e vss npn13G2l m=1

    * Emitter Degeneration
    L_e e vss 50pH

    * Load Inductor
    L_load vdd c 100pH

    * Output coupling
    C_out c out 1pF
.ends

* Supply
V_vdd vdd 0 1.2
V_vss vss 0 0

* Input and Output Ports (50 Ohms)
V1 in 0 dc 0.85 ac 1 portnum=1 z0=50
V2 out 0 dc 1.2 ac 0 portnum=2 z0=50

* Instantiate LNA
X_lna in out vdd vss lna_core

* S-Parameter Analysis
.control
    * Sweep from 20 GHz to 40 GHz, 100 points
    sp dec 50 20G 40G 0

    * Find indices near 30 GHz
    let f30 = 30G
    let freq_diff = abs(frequency - f30)
    let min_diff = vecmin(freq_diff)

    * Print S-parameters at 30 GHz
    print S_1_1 S_2_1 S_1_2 S_2_2

    * Export for plotting
    wrdata s_params.txt S_1_1 S_2_1 S_1_2 S_2_2

    quit
.endc
.end
